* r2r_dac - minimal reference schematic netlist for the ade.lvs gate
* (docs/design.md 1.5, "### M9."). Kept as the LVS reference even after
* M8 merged (docs/design.md "### M8.") its own netlist/r2r_dac.cir: that
* subckt is a 2-bit R2R ladder (pins bmsb/blsb/vout, four PDK rm1
* resistors) built on this PDK's real rm1 device, while
* layout/gen_r2r_dac.py's own docstring fixes its layout at the N=1 base
* case (two resistors, "kept to one stage here so the hand-routing stays
* small enough to verify by hand") - a deliberate, documented boundary,
* not an oversight. LVS against M8's real schematic would fail on a
* genuine bit-width/pin mismatch, not a planted fault, so this stand-in
* stays; extending gen_r2r_dac.py to M8's own bit width is out of scope
* for a rebase.
*
* Matches layout/gen_r2r_dac.py exactly: two matched "2R" poly resistors,
* R_A between VIN and VOUT, R_B between VOUT and GND, both substrate taps
* grounded.
.subckt r2r_dac VIN GND VOUT
xra VIN VOUT GND npolyf_s r_width=0.6u r_length=4u
xrb VOUT GND GND npolyf_s r_width=0.6u r_length=4u
.ends
