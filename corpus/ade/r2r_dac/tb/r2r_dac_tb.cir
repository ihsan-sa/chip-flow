* r2r_dac_tb.cir - the r2r_dac bench (docs/design.md 1.3/5's .bounds.json
* sidecar shape, section 4's optimise target, "### M8."). {{PDK}}/{{CORNER}}/
* {{TEMP_C}}/{{VDD}}/{{NETLIST}}/{{SIZING}} are sim_run.py's own deck
* placeholders (engine/lib/simlib.py:materialize). {{SIZING}} must land
* BEFORE the `xdac` instantiation line below: it is a `.param r_unit=...
* r2_unit=...` line (engine/lib/simlib.py:sizing_param_line) that `xdac`'s
* own `r_unit={r_unit} r2_unit={r2_unit}` args reference as bare globals -
* with no sizing/sizing.yaml present those names are undefined and ngspice
* refuses the deck outright (confirmed empirically - never trust that a
* missing override silently falls back to the subckt's own default; it
* does not, once the CALLER explicitly names the param).
*
* Operating-point start, no `uic`: same reasoning as corpus/ade/mirror's
* own bench - though this ladder is pure resistors (no active devices, no
* real convergence risk), keeping the convention uniform across every ade
* bench is simpler than special-casing the ones that would not have
* needed it.
*
* Four codes swept over one transient: LSB=1 alone at t=15n, MSB=1 alone
* at t=25n, both at t=35n (both-zero at t=5n is not separately measured -
* an unloaded R2R ladder at code 00 is trivially 0V either way).
.include '{{PDK}}/libs.tech/ngspice/design.spice'
.lib '{{PDK}}/libs.tech/ngspice/sm141064.spice' {{CORNER}}
.temp {{TEMP_C}}
{{SIZING}}
.include '{{NETLIST}}'

vdd_src vdd 0 {{VDD}}
vbmsb bmsb 0 PWL(0 0 19.9n 0 20n {{VDD}} 40n {{VDD}})
vblsb blsb 0 PWL(0 0 9.9n 0 10n {{VDD}} 19.9n {{VDD}} 20n 0 29.9n 0 30n {{VDD}} 40n {{VDD}})
xdac bmsb blsb vout r2r_dac r_unit={r_unit} r2_unit={r2_unit}

.tran 0.1n 40n
.measure tran vout_lsb  FIND v(vout) AT=15n
.measure tran vout_msb  FIND v(vout) AT=25n
.measure tran vout_both FIND v(vout) AT=35n

.control
run
.endc
.end
